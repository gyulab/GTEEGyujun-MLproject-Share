// VerilogA for GB_lib, IWO_verliogA, veriloga

//*******************************************************************************
//* * School of Electrical and Computer Engineering, Georgia Institute of Technology
//* PI: Prof. Shimeng Yu
//* All rights reserved.
//*
//* Copyright of the model is maintained by the developers, and the model is distributed under
//* the terms of the Creative Commons Attribution-NonCommercial 4.0 International Public License
//* http://creativecommons.org/licenses/by-nc/4.0/legalcode.
//*
//* THIS SOFTWARE IS PROVIDED BY THE COPYRIGHT HOLDERS AND CONTRIBUTORS "AS IS" AND
//* ANY EXPRESS OR IMPLIED WARRANTIES, INCLUDING, BUT NOT LIMITED TO, THE IMPLIED
//* WARRANTIES OF MERCHANTABILITY AND FITNESS FOR A PARTICULAR PURPOSE ARE
//* DISCLAIMED. IN NO EVENT SHALL THE COPYRIGHT HOLDER OR CONTRIBUTORS BE LIABLE
//* FOR ANY DIRECT, INDIRECT, INCIDENTAL, SPECIAL, EXEMPLARY, OR CONSEQUENTIAL
//* DAMAGES (INCLUDING, BUT NOT LIMITED TO, PROCUREMENT OF SUBSTITUTE GOODS OR
//* SERVICES; LOSS OF USE, DATA, OR PROFITS; OR BUSINESS INTERRUPTION) HOWEVER
//* CAUSED AND ON ANY THEORY OF LIABILITY, WHETHER IN CONTRACT, STRICT LIABILITY,
//* OR TORT (INCLUDING NEGLIGENCE OR OTHERWISE) ARISING IN ANY WAY OUT OF THE USE
//* OF THIS SOFTWARE, EVEN IF ADVISED OF THE POSSIBILITY OF SUCH DAMAGE.
//*
//* Developer:
//*  Gihun Choe gchoe6@gatech.edu
//* Inherited to:
//*  Gyujun Jeong gjeong35@gatech.edu
//********************************************************************************/

`include "constants.vams"
`include "disciplines.vams"

module IWO_verilogA (d, g, s);
	inout d, g, s;
	electrical d, g, s;

	//***** parameters L and W ******//
	parameter real W = 0.1; //get parameter fom spectre
	parameter real L = 0.05; //get parameter fom spectre
	parameter MinVg = -1.0 ;
	parameter normVg = 0.2222222222222222 ;
	parameter MinVd = 0.01 ;
	parameter normVd = 0.2949852507374631 ;
	parameter MinLg = 0.05 ;
	parameter normLg = 1.4285714285714286 ;
	parameter MinO = 8.15e-15 ;
	parameter normO =33613445378151.26;
	parameter MinI = -23.98798356587402 ;
	parameter normI =0.04615548498417793;

	real Vg, Vd, Vs, Vgs, Vds, Lg, Id, Cgg, Cgsd, Vgd, Qgd, Qgs;
	real Vgsraw, Vgdraw, dir;

	real h1_0, h1_1, h1_2, h1_3, h1_4, h1_5, h1_6, h1_7, h1_8, h1_9, h1_10, h1_11, h1_12, h1_13, h1_14, h1_15, h1_16, h1_17, h1_18, h1_19, h1_20, h1_21, h1_22, h1_23, h1_24;
	real h2_0, h2_1, h2_2, h2_3, h2_4, h2_5, h2_6, h2_7, h2_8, h2_9, h2_10, h2_11, y;
	real hc1_0, hc1_1, hc1_2, hc1_3, hc1_4, hc1_5, hc1_6, hc1_7, hc1_8, hc1_9, hc1_10, hc1_11, hc1_12, hc1_13, hc1_14, hc1_15, hc1_16;
	real hc2_0, hc2_1, hc2_2, hc2_3, hc2_4, hc2_5, hc2_6, hc2_7, hc2_8, hc2_9, hc2_10, hc2_11, hc2_12, hc2_13, hc2_14, hc2_15, hc2_16, yc;

	analog function real ReLu;
		input k;
		real k;
		real abs_k;
		begin
			ReLu = (k>0) ? k : 0;
		end
	endfunction

analog begin
	Vg = V(g) ;
	Vs = V(s) ;
	Vd = V(d) ;
	Vgsraw = Vg-Vs ;
	Vgdraw = Vg-Vd ;

if (Vgsraw >= Vgdraw) begin
	Vgs = ((Vg-Vs) - MinVg) * normVg ;
	dir = 1;
end

else begin
	Vgs = ((Vg-Vd) - MinVg) * normVg ;
	dir = -1;
end

	Vds = (abs(Vd-Vs) - MinVd) * normVd ;

	Lg = (L -MinLg)*normLg ;

//******************** C-V NN **********************************//
hc1_0 = ReLu(-0.011703977*Vgs+0.069928646*Vds+-0.09132614*Lg+-0.073745884);
hc1_1 = ReLu(0.6485757*Vgs+-0.07397349*Vds+-0.013209563*Lg+-0.27947083);
hc1_2 = ReLu(-0.17609075*Vgs+-0.020996796*Vds+-0.49876672*Lg+-0.29314095);
hc1_3 = ReLu(-0.49887812*Vgs+-0.4856473*Vds+0.34054476*Lg+-0.5438554);
hc1_4 = ReLu(-0.93455577*Vgs+0.6023342*Vds+0.062077403*Lg+0.52078986);
hc1_5 = ReLu(0.54349333*Vgs+-0.071060725*Vds+-1.3536296*Lg+-0.17802615);
hc1_6 = ReLu(-0.34068272*Vgs+-0.19402632*Vds+0.17135958*Lg+-0.3746291);
hc1_7 = ReLu(0.89730024*Vgs+0.0061596176*Vds+0.01908026*Lg+-0.38150388);
hc1_8 = ReLu(-0.24619892*Vgs+-0.39892522*Vds+-0.53021187*Lg+-0.5585783);
hc1_9 = ReLu(0.4256021*Vgs+-0.37010565*Vds+0.9809879*Lg+0.3371457);
hc1_10 = ReLu(0.834802*Vgs+-0.10541024*Vds+0.18977936*Lg+-0.35459274);
hc1_11 = ReLu(-0.87951267*Vgs+0.12022133*Vds+-0.7424517*Lg+0.38330445);
hc1_12 = ReLu(0.2327851*Vgs+0.21284284*Vds+0.45117888*Lg+-0.026285123);
hc1_13 = ReLu(0.008346946*Vgs+0.122501045*Vds+0.135208*Lg+-0.2827883);
hc1_14 = ReLu(0.48179343*Vgs+0.27122667*Vds+-0.17939106*Lg+0.011169338);
hc1_15 = ReLu(0.33259717*Vgs+0.79229623*Vds+0.026978869*Lg+0.21084641);
hc1_16 = ReLu(0.6358763*Vgs+-0.28348398*Vds+-0.3611664*Lg+0.2164976);

hc2_0 = ReLu(0.32269335*hc1_0+0.34329626*hc1_1+0.21475846*hc1_2+0.2233701*hc1_3+0.49874914*hc1_4+-1.4851182*hc1_5+0.37902924*hc1_6+-0.07983672*hc1_7+0.0068490067*hc1_8+-0.14656812*hc1_9+0.20590524);
hc2_1 = ReLu(-0.335731*hc1_0+0.53642696*hc1_1+-0.33582056*hc1_2+0.30037722*hc1_3+0.6965553*hc1_4+-0.10329459*hc1_5+-0.12900113*hc1_6+0.59866667*hc1_7+-0.14025272*hc1_8+-0.06496858*hc1_9+0.103396);
hc2_2 = ReLu(0.14079906*hc1_0+-0.41843507*hc1_1+-0.38781637*hc1_2+-0.37037304*hc1_3+-0.4370408*hc1_4+-0.58051187*hc1_5+0.11415517*hc1_6+-0.157658*hc1_7+0.3420587*hc1_8+0.16322786*hc1_9+-0.1852727);
hc2_3 = ReLu(-0.22164121*hc1_0+0.22044079*hc1_1+-0.12176521*hc1_2+0.29585713*hc1_3+-0.30140296*hc1_4+0.37719008*hc1_5+-0.39568147*hc1_6+0.13403088*hc1_7+0.14993565*hc1_8+-0.36922923*hc1_9+-0.12044735);
hc2_4 = ReLu(0.40317312*hc1_0+-0.08652171*hc1_1+-0.20294783*hc1_2+-0.17536286*hc1_3+-0.3456652*hc1_4+-0.3350352*hc1_5+0.28033558*hc1_6+0.20134354*hc1_7+0.18732147*hc1_8+-0.06018027*hc1_9+0.17461166);
hc2_5 = ReLu(-0.29843163*hc1_0+-0.21375497*hc1_1+0.25639364*hc1_2+0.27628022*hc1_3+0.6052003*hc1_4+-0.10671685*hc1_5+-0.14927246*hc1_6+0.2792661*hc1_7+-0.18906492*hc1_8+-0.21806215*hc1_9+0.32181495);
hc2_6 = ReLu(0.27992*hc1_0+-0.10397313*hc1_1+0.13410386*hc1_2+-0.32402766*hc1_3+0.048339*hc1_4+-0.25307024*hc1_5+-0.26721787*hc1_6+-0.13081294*hc1_7+-0.06320825*hc1_8+0.44571102*hc1_9+0.049059916);
hc2_7 = ReLu(0.31009117*hc1_0+0.35248142*hc1_1+0.00027007022*hc1_2+0.20439062*hc1_3+0.22932686*hc1_4+0.78571844*hc1_5+-0.33706054*hc1_6+0.8383826*hc1_7+0.37830833*hc1_8+-0.03843894*hc1_9+0.06336992);
hc2_8 = ReLu(-0.29707438*hc1_0+-0.013794513*hc1_1+0.16682106*hc1_2+-0.27500054*hc1_3+-0.1925894*hc1_4+0.29996702*hc1_5+0.013861668*hc1_6+0.30680832*hc1_7+0.19665249*hc1_8+-0.21763423*hc1_9+-0.20662364);
hc2_9 = ReLu(0.0046983045*hc1_0+-0.2886854*hc1_1+0.25531182*hc1_2+0.24104945*hc1_3+-0.34337538*hc1_4+-0.46490118*hc1_5+0.28547624*hc1_6+0.032101292*hc1_7+0.14667152*hc1_8+0.44629794*hc1_9+0.12290087);
hc2_10 = ReLu(0.23699485*hc1_0+-0.3026429*hc1_1+-0.11402957*hc1_2+0.04117161*hc1_3+-0.08818656*hc1_4+-0.021662837*hc1_5+0.11565666*hc1_6+0.019738307*hc1_7+0.36112574*hc1_8+-0.27927825*hc1_9+-0.22951613);
hc2_11 = ReLu(0.14197205*hc1_0+-0.27815315*hc1_1+-0.32893205*hc1_2+-0.057118174*hc1_3+-0.037273295*hc1_4+0.31590122*hc1_5+-0.12924755*hc1_6+-0.23770125*hc1_7+0.046157718*hc1_8+-0.1630921*hc1_9+0.06381819);
hc2_12 = ReLu(-0.17525153*hc1_0+0.08661652*hc1_1+-0.12033579*hc1_2+-0.2795748*hc1_3+0.9509718*hc1_4+-0.014778866*hc1_5+0.19457199*hc1_6+-0.0022905006*hc1_7+-0.21720742*hc1_8+-0.25886002*hc1_9+0.10214604);
hc2_13 = ReLu(0.13995962*hc1_0+0.30794472*hc1_1+0.18661577*hc1_2+-0.2792481*hc1_3+-0.36683503*hc1_4+-0.11610385*hc1_5+0.34350812*hc1_6+-0.11263314*hc1_7+-0.08190995*hc1_8+-0.08647654*hc1_9+-0.13609394);
hc2_14 = ReLu(-0.39574978*hc1_0+0.5925933*hc1_1+0.20001456*hc1_2+0.06900311*hc1_3+-0.1511596*hc1_4+-3.4609706*hc1_5+0.2909454*hc1_6+0.7880743*hc1_7+-0.1530918*hc1_8+0.3571122*hc1_9+0.2514284);
hc2_15 = ReLu(-0.19498561*hc1_0+-0.28105366*hc1_1+-0.009438736*hc1_2+0.27924615*hc1_3+0.17243965*hc1_4+-0.17519422*hc1_5+-0.18129168*hc1_6+0.21013847*hc1_7+-0.1785364*hc1_8+0.15811716*hc1_9+-0.2842865);
hc2_16 = ReLu(-0.17381676*hc1_0+0.32967702*hc1_1+0.13156946*hc1_2+0.08157573*hc1_3+0.079741076*hc1_4+0.026836006*hc1_5+-0.070694745*hc1_6+0.053815786*hc1_7+0.39139223*hc1_8+-0.06457427*hc1_9+-0.07380797);
yc = 1.019306*hc2_0+-1.3365554*hc2_1+0.3894494*hc2_2+0.4572135*hc2_3+0.36477262*hc2_4+0.2383517;

Cgg = (yc / normO + MinO)*W;
Cgsd = Cgg/2 ;

//******************** I-V NN **********************************//
h1_0 = ReLu(0.09788056*Vgs+0.2190511*Vds+0.23961835*Lg+0.3801769);
h1_1 = ReLu(0.53084403*Vgs+-0.084122606*Vds+-0.00031996422*Lg+-0.28257433);
h1_2 = ReLu(-0.056323484*Vgs+-0.036748465*Vds+0.04072938*Lg+-0.1988864);
h1_3 = ReLu(0.10250498*Vgs+-0.044000074*Vds+0.30715084*Lg+-0.41182938);
h1_4 = ReLu(0.31034473*Vgs+-0.44728085*Vds+-0.013986457*Lg+0.4494959);
h1_5 = ReLu(-0.9858995*Vgs+0.110269375*Vds+0.0006725706*Lg+0.3810927);
h1_6 = ReLu(-0.29189414*Vgs+0.6799901*Vds+0.17172906*Lg+0.29155213);
h1_7 = ReLu(-0.32132596*Vgs+-0.0097757*Vds+0.10748861*Lg+-0.28261802);
h1_8 = ReLu(-0.33015445*Vgs+-0.23820448*Vds+0.40033427*Lg+-0.54186887);
h1_9 = ReLu(-0.41042843*Vgs+-0.42772698*Vds+0.338848*Lg+-0.46522915);
h1_10 = ReLu(0.18244573*Vgs+-1.1730053*Vds+-0.010333413*Lg+0.76337147);
h1_11 = ReLu(-0.30577496*Vgs+-0.3280476*Vds+-0.2184883*Lg+-0.052213993);
h1_12 = ReLu(-0.30546075*Vgs+-0.331876*Vds+-0.06070012*Lg+-0.13489966);
h1_13 = ReLu(-0.30906034*Vgs+0.2792654*Vds+0.26444134*Lg+-0.5476529);
h1_14 = ReLu(-0.23288453*Vgs+0.3537474*Vds+-0.13017972*Lg+0.35463452);
h1_15 = ReLu(0.3175044*Vgs+0.5670776*Vds+-0.3341659*Lg+0.36601317);
h1_16 = ReLu(0.54017663*Vgs+0.4469894*Vds+0.22001025*Lg+0.5447434);
h1_17 = ReLu(-0.34334213*Vgs+0.040327035*Vds+-0.42741674*Lg+-0.04739348);
h1_18 = ReLu(-1.6026081*Vgs+0.5132873*Vds+0.002163324*Lg+-0.12790777);
h1_19 = ReLu(-0.007594915*Vgs+1.004012*Vds+0.00018869067*Lg+-0.017248377);
h1_20 = ReLu(-0.06206749*Vgs+-0.39475238*Vds+0.1786294*Lg+0.45297712);
h1_21 = ReLu(-0.045956057*Vgs+-0.27667627*Vds+0.032326084*Lg+-0.2888271);
h1_22 = ReLu(-0.44694486*Vgs+0.52978945*Vds+-0.0060722968*Lg+0.45298886);
h1_23 = ReLu(0.49681094*Vgs+-0.47836724*Vds+-0.006866803*Lg+0.16582224);
h1_24 = ReLu(-1.1019777*Vgs+0.06079818*Vds+0.0019168813*Lg+0.35628262);

h2_0 = ReLu(-0.2047909*h1_0+0.22798623*h1_1+-0.027930548*h1_2+-0.37643754*h1_3+0.16192332*h1_4+0.0664962*h1_5+-0.24535173*h1_6+0.37537146*h1_7+-0.1463306*h1_8+0.23348254*h1_9+-0.26218334*h1_10+-0.07362528*h1_11+-0.12487125*h1_12+0.21364598*h1_13+0.3361944*h1_14+-0.39792734*h1_15+-0.3147231*h1_16+-0.03703404*h1_17+0.2727355*h1_18+0.22811191*h1_19+0.35758233*h1_20+0.3983948*h1_21+-0.22459807*h1_22+0.005667305*h1_23+0.18252826*h1_24+0.05969751);
h2_1 = ReLu(0.16057363*h1_0+0.17103902*h1_1+0.28487584*h1_2+0.074357286*h1_3+0.07956639*h1_4+0.3350666*h1_5+-0.083376884*h1_6+-0.042765766*h1_7+0.041527964*h1_8+-0.3923324*h1_9+0.093216255*h1_10+-0.13680376*h1_11+0.18827045*h1_12+-0.24370103*h1_13+0.33592182*h1_14+0.41496733*h1_15+0.16339771*h1_16+0.13844118*h1_17+0.644442*h1_18+-0.24019106*h1_19+-0.28443944*h1_20+-0.29743725*h1_21+0.2475165*h1_22+-0.03824137*h1_23+-0.16831006*h1_24+0.035854015);
h2_2 = ReLu(-0.35250244*h1_0+0.19751872*h1_1+-0.20000312*h1_2+0.07358026*h1_3+-0.22322199*h1_4+0.103297636*h1_5+-0.09667494*h1_6+0.3782534*h1_7+-0.09755972*h1_8+0.11044757*h1_9+-0.12924036*h1_10+0.33279285*h1_11+0.36412343*h1_12+-0.032456253*h1_13+0.38430995*h1_14+-0.26235917*h1_15+-0.15973517*h1_16+-0.10690659*h1_17+-0.30060318*h1_18+0.18581702*h1_19+0.048500136*h1_20+0.08582941*h1_21+0.22956721*h1_22+0.26075682*h1_23+0.023860652*h1_24+-0.08724842);
h2_3 = ReLu(0.15311153*h1_0+0.3285339*h1_1+-0.19674248*h1_2+0.025072718*h1_3+-0.07597622*h1_4+0.5170585*h1_5+0.15893106*h1_6+-0.062471937*h1_7+0.062160917*h1_8+-0.15648045*h1_9+0.40356287*h1_10+-0.33014604*h1_11+0.02777127*h1_12+-0.3100136*h1_13+0.07834122*h1_14+0.07717723*h1_15+-0.39492565*h1_16+-0.33360118*h1_17+-0.7127235*h1_18+-0.1873319*h1_19+0.32156503*h1_20+-0.33082408*h1_21+0.3722481*h1_22+-1.3629622*h1_23+0.5894517*h1_24+-0.17538758);
h2_4 = ReLu(0.35719708*h1_0+0.18915859*h1_1+0.08963624*h1_2+-0.35601264*h1_3+0.073390745*h1_4+-0.3461345*h1_5+0.073750064*h1_6+-0.15154426*h1_7+0.15506935*h1_8+-0.089347295*h1_9+-0.42119962*h1_10+0.2928763*h1_11+0.107831694*h1_12+0.119730115*h1_13+-0.27707577*h1_14+0.09945942*h1_15+0.3820044*h1_16+-0.35420933*h1_17+0.7232209*h1_18+-0.76801115*h1_19+-0.3322645*h1_20+-0.122752555*h1_21+0.19748978*h1_22+0.46147484*h1_23+-0.0016279924*h1_24+0.10773168);
h2_5 = ReLu(-0.32759738*h1_0+-0.0805269*h1_1+0.2275584*h1_2+-0.029050464*h1_3+-0.39375913*h1_4+-0.318203*h1_5+0.22814745*h1_6+0.20878382*h1_7+0.22023307*h1_8+0.33056283*h1_9+0.20051783*h1_10+0.37626535*h1_11+0.0047562215*h1_12+0.25092056*h1_13+-0.515927*h1_14+0.18741845*h1_15+0.26979792*h1_16+0.102650665*h1_17+1.2574456*h1_18+0.5318359*h1_19+-0.14305884*h1_20+0.32631665*h1_21+0.12965019*h1_22+-0.17201212*h1_23+-0.60672206*h1_24+-0.033850048);
h2_6 = ReLu(0.25504306*h1_0+-0.0014908111*h1_1+0.08956014*h1_2+0.029861698*h1_3+0.522592*h1_4+-0.574793*h1_5+-0.47153127*h1_6+0.18615742*h1_7+0.29927775*h1_8+-0.2098789*h1_9+-0.4048547*h1_10+-0.22652885*h1_11+-0.3299346*h1_12+-0.088373914*h1_13+-0.38821763*h1_14+0.23637979*h1_15+0.14401364*h1_16+0.22901008*h1_17+-0.8528724*h1_18+0.3625017*h1_19+0.04775667*h1_20+0.23436798*h1_21+-0.39704755*h1_22+0.4236627*h1_23+-0.5073619*h1_24+0.27136222);
h2_7 = ReLu(-0.0937255*h1_0+-0.14729582*h1_1+0.3136273*h1_2+-0.0051041613*h1_3+0.0016025867*h1_4+0.027412094*h1_5+0.2832549*h1_6+0.023093391*h1_7+-0.33051434*h1_8+-0.14921574*h1_9+0.15998518*h1_10+0.12212196*h1_11+-0.055060904*h1_12+-0.14360753*h1_13+-0.44016585*h1_14+0.27552325*h1_15+-0.15347742*h1_16+-0.12823513*h1_17+-0.014278746*h1_18+0.074603416*h1_19+-0.46107087*h1_20+-0.1461794*h1_21+-0.05764766*h1_22+0.10237763*h1_23+-0.12900935*h1_24+-0.22043712);
h2_8 = ReLu(0.22761668*h1_0+-0.36902162*h1_1+-0.34712422*h1_2+0.14543037*h1_3+-0.03181972*h1_4+0.2551247*h1_5+-0.06009003*h1_6+0.29463565*h1_7+-0.25081304*h1_8+-0.25084603*h1_9+-0.41248676*h1_10+-0.32569888*h1_11+0.058127116*h1_12+0.14110579*h1_13+0.20931372*h1_14+0.49749663*h1_15+0.21600686*h1_16+0.28018448*h1_17+0.77357465*h1_18+-0.3340882*h1_19+0.3227608*h1_20+0.30511793*h1_21+-0.29206222*h1_22+0.2127003*h1_23+-0.51143587*h1_24+0.15145306);
h2_9 = ReLu(0.35373998*h1_0+-0.014796696*h1_1+0.2880789*h1_2+0.054759663*h1_3+-0.25504827*h1_4+-0.9039987*h1_5+0.1159058*h1_6+0.039809488*h1_7+-0.22828804*h1_8+0.100425124*h1_9+0.46251765*h1_10+-0.1906223*h1_11+-0.08352618*h1_12+-0.09896819*h1_13+-0.14238676*h1_14+0.50018394*h1_15+0.35429373*h1_16+0.101014614*h1_17+-0.07933843*h1_18+-0.69530153*h1_19+-0.22556338*h1_20+-0.2561314*h1_21+0.19504508*h1_22+0.001260009*h1_23+-0.7052989*h1_24+-0.015387063);
h2_10 = ReLu(-0.33540344*h1_0+0.1760695*h1_1+-0.10487854*h1_2+-0.35418424*h1_3+0.1412084*h1_4+-0.22072962*h1_5+-0.22970279*h1_6+-0.22247685*h1_7+-0.21490559*h1_8+0.031613864*h1_9+0.17319569*h1_10+0.30688557*h1_11+0.067430355*h1_12+-0.19809732*h1_13+-0.363355*h1_14+-0.2606921*h1_15+-0.19518103*h1_16+0.02097369*h1_17+-0.03421275*h1_18+-0.38514048*h1_19+0.13706212*h1_20+-0.3948907*h1_21+-0.28618473*h1_22+-0.060483146*h1_23+-0.20229937*h1_24+0.07265025);
h2_11 = ReLu(-0.111374766*h1_0+-0.3190863*h1_1+0.048559327*h1_2+0.2166231*h1_3+-0.32965216*h1_4+-0.1833162*h1_5+0.08746466*h1_6+0.089062914*h1_7+-0.08105038*h1_8+0.15124145*h1_9+-0.42336038*h1_10+0.19969718*h1_11+0.30882165*h1_12+-0.19159964*h1_13+0.11311573*h1_14+0.43994233*h1_15+0.4067026*h1_16+0.15090784*h1_17+0.6423348*h1_18+-0.3332669*h1_19+0.0185283*h1_20+-0.11558879*h1_21+0.45414042*h1_22+0.11241549*h1_23+-0.108027585*h1_24+0.014968031);
y = -0.34634525*h2_0+0.13906528*h2_1+0.06286841*h2_2+-0.43577418*h2_3+0.5669899*h2_4+-0.24715464*h2_5+-0.67069423*h2_6+-0.4607318*h2_7+0.6292634*h2_8+0.7582898*h2_9+0.32853714*h2_10+0.33683327*h2_11+-0.08009307;

	Id = pow(10, (y/normI + MinI)) ;

if (Id <= 1e-15) begin //limit
	Id = 1e-15;
	//Id = Id;
end
else begin
	Id = Id;
end  //limit end

//	I(g, d) <+ Cgsd*ddt(Vg-Vd) ;
//	I(g, s) <+ Cgsd*ddt(Vg-Vs) ;
    Qgd = Cgsd * V(g, d);
    Qgs = Cgsd * V(g, s);
    I(g, d) <+ ddt(Qgd);
    I(g, s) <+ ddt(Qgs);

if (Vgsraw >= Vgdraw) begin
	I(d, s) <+ dir*Id*W ;

end

else begin
	I(d, s) <+ dir*Id*W ;

end

end

endmodule
